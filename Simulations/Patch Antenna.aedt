# Ansys Electronics Desktop project, version 2021.1
project variables:
  $radome_distance = 25mm
materials:
  vacuum: permittivity=1
  FR4_epoxy: permittivity=4.4 dielectric_loss_tangent=0.02
  air: permittivity=1.0006 permeability=1.0000004
  copper: permeability=0.999991 conductivity=58000000
  PMMA: permittivity=2.8 conductivity=1e-16 dielectric_loss_tangent=0.001 lande_g_factor=2 delta_H_freq=6000000000

design HFSSDesign1 (HFSS, DrivenModal, model units mm)
geometry:
  substrate [FR4_epoxy] = box(corner=(-20mm, 20mm, 0.0035mm), size=(40mm, -40mm, 1.6mm))
  Radiation [air] = box(corner=(-50mm, -50mm, -50mm), size=(100mm, 100mm, 100mm))
  Ground [copper] = box(corner=(-20mm, -20mm, 0mm), size=(40mm, 40mm, 0.0035mm))
  Patch [copper] = box(corner=(-7.563mm, 3mm, 1.6035mm), size=(15.126mm, 11.32mm, 0.0035mm))
  Inset = box(corner=(-2.49mm, 3mm, 1.6035mm), size=($inset_width, $inset_depth, 0.0035mm))
  Feed = box(corner=(-1.495mm, 7mm, 1.6035mm), size=(2.99mm, -27mm, 0.0035mm))
  Patch.subtract(Inset)
  Patch.unite(Feed)
  Port = rectangle(corner=(-1.495mm, -20mm, 1.607mm), z_size=-1.607mm, x_size=2.995mm)
  Cylinder1 [PMMA] = cylinder(axis=Z, base_centre=(0mm, 0mm, 1.6035mm+$radome_distance), radius=25mm, height=14.95mm)
boundaries and excitations:
  Rad1: Radiation Objects=Radiation
  1: Lumped Port Objects=Port Modes{Mode1{IntLine{middle of Ground.edge(4 of 12) -> middle of Port.edge(z at corner)} CharImp=Zpi RenormImp=50ohm}} Impedance=50ohm
setups:
  Setup1: HfssDriven MultipleAdaptiveFreqsSetup{AdaptAt{Frequency=3GHz Delta=0.02} AdaptAt{Frequency=6GHz Delta=0.02} AdaptAt{Frequency=9GHz Delta=0.02}} MaximumPasses=20 MinimumPasses=1 MinimumConvergedPasses=1 PercentRefinement=30 BasisOrder=1 PortAccuracy=2
    sweep Sweep: 4GHz to 7.5GHz step 0.02GHz; Type=Fast SaveFields
source amplitudes:
  1:1: 1W 0deg
radiation setups:
  E Plane: Infinite Sphere Theta=-180deg..180deg step 5deg Phi=0deg..0deg step 1deg
  H Plane: Infinite Sphere Theta=-180deg..180deg step 5deg Phi=90deg..90deg step 1deg
  3D: Infinite Sphere Theta=-180deg..180deg step 5deg Phi=0deg..360deg step 5deg
field plots:
  Mag_E1: E Field on Setup1 : LastAdaptive at Freq=3GHz Phase=90deg
reports:
  Gain Plot 1: dB(GainTotal) vs Theta on Setup1 : LastAdaptive, E Plane [Phi=all Freq=6GHz]
